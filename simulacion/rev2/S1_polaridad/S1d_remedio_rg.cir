S1d-R remedio: resistencia de gate de Q5 (R_g) menor, BAT +25.2 V -> -25.2 V en 1 ms (caso 1), sin carga
.include ..\modelos\SiRS4401DP_PS.TXT
* Modelos de standard.dio de LTspice. Zener BZX84C12L con Cjo=1p, igual que S2 (DESVIACION: la libreria trae 150p; en S2 con 150p no converge en la rampa de 25.2 V). QTLP690C literal. NO son el MM3Z12VT1G ni el LED real.
.model BZX84C12L D(Is=.6n Rs=.5 Cjo=1p nbv=5 bv=12 Ibv=1m Vpk=12 mfg=OnSemi type=Zener)
.model QTLP690C D(Is=1e-22 Rs=6 N=1.5 Cjo=50p Xti=100 Iave=160m Vpk=5 mfg=Fairchild type=LED)
.options solver=alt method=modtrap
.param RBAT=20m LCAB=0.5u ILD=0 CASO=1 RG=47k
* CASO 1: +25.2 -> -25.2 V en 1 ms continuo (0.5 ms por tramo, pasa por 0 V; peor dV/dt = 50 V/ms)
* (sin carga, ILD=0). R_g = resistencia de gate a GND (valor base 47k)
.param TL={CASO*0.5m} TH={(CASO-1)*1m+1n}
.step param RG list 47k 22k 10k 4.7k 2.2k 1k
VBAT n0 0 PWL(0 25.2 6m 25.2 {6m+TL} 0 {6m+TL+TH} 0 {6m+2*TL+TH} -25.2 14m -25.2)
Rbat n0 n1 {RBAT}
Lcab n1 n2 {LCAB}
Rf1 n2 n3 1.92m
Vid n3 dq 0
XQ5 dq g vbus SiRS4401DP
Rg g 0 {RG}
DZ g vbus BZX84C12L
Cp vbus p1 100u
Rp p1 0 31m
Cc vbus c1 10u
Rc c1 0 3m
Cn vbus n1b 100n
Rn n1b 0 10m
DL vbus la QTLP690C
Rl la 0 4.7k
Bld vbus 0 I={ILD}*limit(V(vbus)/3,0,1)
.save V(g) V(vbus) V(dq) I(Vid) I(Rg)
.tran 0 14m 0 1u
* --- mediciones (sin exceder maximos de la pieza: |V_GS| <= 20 V, V_DS inverso <= 40 V) ---
.meas tran vgs_min min v(g)-v(vbus) from=6m
.meas tran vgs_max max v(g)-v(vbus) from=6m
.meas tran vds_fwd max v(dq)-v(vbus) from=6m
.meas tran vds_rev max v(vbus)-v(dq) from=6m
.meas tran vbus_max max v(vbus) from=6m
.meas tran vbus_min min v(vbus) from=6m
.meas tran vbus_end avg v(vbus) from=13m to=14m
.meas tran i_pk max i(Vid) from=6m
.meas tran i_min min i(Vid) from=6m
.meas tran ig_dc avg i(Rg) from=1m to=5m
.meas tran pz param abs(ig_dc)*12
.meas tran p_pk max abs((v(dq)-v(vbus))*i(Vid)) from=6m
.end
