S1d proteccion de polaridad Q5 - BAT de +25.2 V a 0 V y a -25.2 V
.include ..\modelos\SiRS4401DP_PS.TXT
* Modelos de standard.dio de LTspice. Zener BZX84C12L con Cjo=1p, igual que S2 (DESVIACION: la libreria trae 150p; en S2 con 150p no converge en la rampa de 25.2 V). QTLP690C literal. NO son el MM3Z12VT1G ni el LED real.
.model BZX84C12L D(Is=.6n Rs=.5 Cjo=1p nbv=5 bv=12 Ibv=1m Vpk=12 mfg=OnSemi type=Zener)
.model QTLP690C D(Is=1e-22 Rs=6 N=1.5 Cjo=50p Xti=100 Iave=160m Vpk=5 mfg=Fairchild type=LED)
.options solver=alt method=modtrap
.param RBAT=20m LCAB=0.5u ILD=0 CASO=1
* CASO 1: +25.2 -> -25.2 V en 1 ms continuo (0.5 ms por tramo, pasa por 0 V; peor dV/dt = 50 V/ms)
* CASO 2: +25.2 -> 0 en 1 ms, 1 ms en 0 V, 0 -> -25.2 en 1 ms
* CASO 3: +25.2 -> -25.2 V en 10 us (conexion inversa abrupta con C_IN cargado; no pedido por el handoff, peor caso extra)
* ILD: carga del convertidor (A), se apaga al caer VBUS: ILD*limit(V(VBUS)/3,0,1)
.param TL={if(CASO==1,0.5m,if(CASO==2,1m,5u))} TH={if(CASO==2,1m,1n)}
.step param ILD list 0 12
.step param CASO list 1 2 3
VBAT n0 0 PWL(0 25.2 6m 25.2 {6m+TL} 0 {6m+TL+TH} 0 {6m+2*TL+TH} -25.2 14m -25.2)
Rbat n0 n1 {RBAT}
Lcab n1 n2 {LCAB}
Rf1 n2 n3 1.92m
Vid n3 dq 0
XQ5 dq g vbus SiRS4401DP
Rg g 0 47k
DZ g vbus BZX84C12L
Cp vbus p1 100u
Rp p1 0 31m
Cc vbus c1 10u
Rc c1 0 3m
Cn vbus n1b 100n
Rn n1b 0 10m
DL vbus la QTLP690C
Rl la 0 4.7k
Bld vbus 0 I={ILD}*limit(V(vbus)/3,0,1)
.save V(g) V(vbus) V(dq) I(Vid)
.tran 0 14m 0 1u
* --- mediciones (sin exceder maximos de la pieza: |V_GS| <= 20 V, V_DS inverso <= 40 V) ---
.meas tran vgs_min min v(g)-v(vbus) from=6m
.meas tran vgs_max max v(g)-v(vbus) from=6m
.meas tran vds_fwd max v(dq)-v(vbus) from=6m
.meas tran vds_rev max v(vbus)-v(dq) from=6m
.meas tran vbus_max max v(vbus) from=6m
.meas tran vbus_min min v(vbus) from=6m
.meas tran vbus_end avg v(vbus) from=13m to=14m
.meas tran i_pk max i(Vid) from=6m
.meas tran i_min min i(Vid) from=6m
.meas tran p_pk max abs((v(dq)-v(vbus))*i(Vid)) from=6m
.end
