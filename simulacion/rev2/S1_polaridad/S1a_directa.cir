S1a proteccion de polaridad Q5 - polaridad directa, 12 A continuos y pulso 23 A 10 ms
.include ..\modelos\SiRS4401DP_PS.TXT
* Modelos de standard.dio de LTspice. Zener BZX84C12L con Cjo=1p, igual que S2 (DESVIACION: la libreria trae 150p; en S2 con 150p no converge en la rampa de 25.2 V). QTLP690C literal. NO son el MM3Z12VT1G ni el LED real.
.model BZX84C12L D(Is=.6n Rs=.5 Cjo=1p nbv=5 bv=12 Ibv=1m Vpk=12 mfg=OnSemi type=Zener)
.model QTLP690C D(Is=1e-22 Rs=6 N=1.5 Cjo=50p Xti=100 Iave=160m Vpk=5 mfg=Fairchild type=LED)
.options solver=alt method=modtrap
.param VB=12 RBAT=20m LCAB=0.5u
.step param VB list 6 7.4 12 16.8 25.2
.step temp list 25 100
* bateria + cable + fusible F1 (1.92 mohm en frio, Littelfuse 0456025.ER)
* bateria ya conectada (OP con Q5 encendido); el arranque en caliente se simula en S2
VBAT n0 0 {VB}
Rbat n0 n1 {RBAT}
Lcab n1 n2 {LCAB}
Rf1 n2 n3 1.92m
Vid n3 dq 0
* Q5: drain a bateria, source a VBUS, 47k gate-GND, zener 12 V gate-source (catodo en source)
XQ5 dq g vbus SiRS4401DP
Rg g 0 47k
DZ g vbus BZX84C12L
* C_IN: 100u polimero ESR 31m (KEMET A759KS107M1V E031) + 10u (3m) + 100n (10m)
Cp vbus p1 100u
Rp p1 0 31m
Cc vbus c1 10u
Rc c1 0 3m
Cn vbus n1b 100n
Rn n1b 0 10m
* LED1 + 4.7k
DL vbus la QTLP690C
Rl la 0 4.7k
* carga: 12 A desde 1 ms, pulso 23 A de 5 a 15 ms, vuelve a 12 A
Iload vbus 0 PWL(0 0 1m 0 1.005m 12 5m 12 5.005m 23 15m 23 15.005m 12 17m 12)
.save V(g) V(vbus) V(dq) I(Vid)
.tran 0 17m 0 1u
* --- mediciones (|V_GS| <= 15 V; P(12 A) <= 1 W) ---
.meas tran vgs12 avg v(g)-v(vbus) from=3m to=4.9m
.meas tran vds12 avg v(dq)-v(vbus) from=3m to=4.9m
.meas tran id12 avg i(Vid) from=3m to=4.9m
.meas tran p12 avg (v(dq)-v(vbus))*i(Vid) from=3m to=4.9m
.meas tran rds12 param vds12/id12*1000
.meas tran vbus12 avg v(vbus) from=3m to=4.9m
.meas tran vgs23 avg v(g)-v(vbus) from=13m to=14.9m
.meas tran vds23 avg v(dq)-v(vbus) from=13m to=14.9m
.meas tran id23 avg i(Vid) from=13m to=14.9m
.meas tran p23 avg (v(dq)-v(vbus))*i(Vid) from=13m to=14.9m
.meas tran rds23 param vds23/id23*1000
* estimacion (NO del modelo): R_DS(on) maxima de datasheet / R del modelo ~ 2.9 mohm / 1.96 mohm ~ 1.5
.param KPEOR=1.5
.meas tran p12_peor param p12*KPEOR
.meas tran vgs_min min v(g)-v(vbus)
.meas tran vgs_max max v(g)-v(vbus)
.meas tran vds_pk max abs(v(dq)-v(vbus)) from=0.9m
.meas tran vbus_min min v(vbus) from=0.9m
.meas tran vbus_pk max v(vbus)
.end
